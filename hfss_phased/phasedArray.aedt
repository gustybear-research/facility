# Ansys Electronics Desktop project, version 2020.2
materials:
  vacuum: permittivity=1
  Arlon AD410 (tm): permittivity=4.1 dielectric_loss_tangent=0.003
  air: permittivity=1.0006 permeability=1.0000004
  PMLGroup1_Z_1: permittivity{anisotropic component1=1.1338425 component2=1.1338425 component3=0.44097836} permeability{anisotropic component1=1.1338425 component2=1.1338425 component3=0.44097836} dielectric_loss_tangent{anisotropic component1=1 component2=1 component3=-1} magnetic_loss_tangent{anisotropic component1=1 component2=1 component3=-1}
  PMLGroup1_XZ_1: permittivity{anisotropic component1=1 component2=0.01 component3=1} permeability{anisotropic component1=1 component2=0.01 component3=1} dielectric_loss_tangent{anisotropic component1=0 component2=257.11976 component3=0} magnetic_loss_tangent{anisotropic component1=0 component2=257.11976 component3=0}
  PMLGroup1_YZ_1: permittivity{anisotropic component1=0.01 component2=1 component3=1} permeability{anisotropic component1=0.01 component2=1 component3=1} dielectric_loss_tangent{anisotropic component1=257.11976 component2=0 component3=0} magnetic_loss_tangent{anisotropic component1=257.11976 component2=0 component3=0}
  PMLGroup1_XYZ_1: permittivity{anisotropic component1=1.1338425 component2=1.1338425 component3=1.1338425} permeability{anisotropic component1=1.1338425 component2=1.1338425 component3=1.1338425} dielectric_loss_tangent{anisotropic component1=1 component2=1 component3=1} magnetic_loss_tangent{anisotropic component1=1 component2=1 component3=1}
  Rogers RT/duroid 5880 (tm): permittivity=2.2 dielectric_loss_tangent=0.0009

design 2_1_singlecolumn (HFSS, DrivenModal, model units mm)
variables:
  subX = 25mm
  subY = 50mm
  subZ = 0.3mm
  patchW = 3.25mm
  patchL = 2.85mm
  arraySpaceL = 2.65mm
  qwtWidth = 0.3mm
  fiftyOhmW = 0.85mm
geometry:
  substrate [Arlon AD410 (tm)] = box(corner=(-subX/2, -subY/2, -subZ), size=(subX, subY, subZ))
  patch1 = rectangle(corner=(-patchW/2, 0mm, 0mm), x_size=patchW, y_size=patchL)
  patch2 = rectangle(corner=(-patchW/2, 1 * (patchL + arraySpaceL), 0mm), x_size=patchW, y_size=patchL)
  patch3 = rectangle(corner=(-patchW/2, 2*(patchL + arraySpaceL ), 0mm), x_size=patchW, y_size=patchL)
  patch4 = rectangle(corner=(-patchW/2, 3*(patchL + arraySpaceL), 0mm), x_size=patchW, y_size=patchL)
  QWTtrace = rectangle(corner=(-qwtWidth/2, -arraySpaceL, 0mm), x_size=qwtWidth, y_size=4*patchL + 4*arraySpaceL)
  50ohm = rectangle(corner=(-fiftyOhmW/2, -5mm - arraySpaceL, 0mm), x_size=fiftyOhmW, y_size=5mm)
  50ohm.unite(QWTtrace, patch1..patch4)
  Rectangle1 = rectangle(corner=(-fiftyOhmW/2, -(arraySpaceL + 5mm), -subZ), z_size=subZ, x_size=fiftyOhmW)
  RadiatingSurface [vacuum] = region(absolute_offset=3.5714286mm on all sides)
  coordinate_system RelativeCS1 = origin=(-0.15mm, 9.675mm, 0mm) x=(1mm, 0mm, 0mm) y=(0mm, 1mm, 0mm)
boundaries and excitations:
  ground: Perfect E Faces=substrate.face(-z)
  goldTrace: Finite Conductivity Faces=50ohm.face(at (0, -5.15, 0)) Conductivity=41100000 Permeability=1 IsInternal
  Open1: Radiation Objects=RadiatingSurface
  port1: Lumped Port Objects=Rectangle1 Modes{Mode1{IntLine{middle of Rectangle1.edge(z opposite corner) -> middle of Rectangle1.edge(z at corner)} CharImp=Zpi RenormImp=50ohm}} Impedance=50ohm
setups:
  Setup1: HfssDriven Frequency=28GHz MaxDeltaS=0.02 MaximumPasses=6 MinimumPasses=1 MinimumConvergedPasses=1 PercentRefinement=30 BasisOrder=0 PortAccuracy=2
    sweep Sweep: 20GHz to 36GHz, 401 points; Type=Interpolating InterpTolerance=0.2 InterpMaxSolns=250 InterpUsePortImped=false PassivityErrorTolerance=0.0001
source amplitudes:
  port1:1: 1W 0deg
radiation setups:
  3D: Infinite Sphere Theta=0deg..180deg step 2deg Phi=-180deg..180deg step 2deg
  Elevation: Infinite Sphere Theta=-180deg..180deg step 1deg Phi=0deg..90deg step 90deg
  Azimuth: Infinite Sphere Theta=90deg..90deg step 0deg Phi=-180deg..180deg step 1deg
  ff_2d: Infinite Sphere Theta=-180deg..180deg step 2deg Phi=0deg..90deg step 90deg
  Infinite Sphere1: Infinite Sphere Theta=0deg..180deg step 2deg Phi=0deg..360deg step 2deg
  coord: Infinite Sphere Theta=0deg..180deg step 2deg Phi=0deg..360deg step 2deg CoordSystem=RelativeCS1
reports:
  Gain Plot 1: dB(GainTotal) vs Phi, Theta on Setup1 : LastAdaptive, 3D [Freq=28GHz]
  Gain Plot 2: dB(GainTotal) vs Phi, Theta on Setup1 : LastAdaptive, coord [Freq=28GHz]
  Gain Plot 3: dB(GainTotal) vs Theta on Setup1 : LastAdaptive, ff_2d [Phi=all Freq=28GHz]
  Directivity Plot 1: dB(DirTotal) vs Theta on Setup1 : LastAdaptive, ff_2d [Phi=all Freq=28GHz]; markers m1 at 0deg

design fullarray (HFSS, DrivenModal, model units mm)
variables:
  subX = 32mm
  subY = 40mm
  subZ = 0.3mm
  patchW = 3.25mm
  patchL = 2.85mm
  arraySpaceL = 2.65mm
  qwtWidth = 0.3mm
  fiftyOhmW = 0.85mm
  antennaSpacing = ((6.25 +  0.15)/2) mm
  dt = 0deg
geometry:
  substrate [Arlon AD410 (tm)] = box(corner=(-6mm, -15mm, -subZ), size=(subX, subY, subZ))
  patch1 = rectangle(corner=(-patchW/2, 0mm, 0mm), x_size=patchW, y_size=patchL)
  patch2 = rectangle(corner=(-patchW/2, 1 * (patchL + arraySpaceL), 0mm), x_size=patchW, y_size=patchL)
  patch3 = rectangle(corner=(-patchW/2, 2*(patchL + arraySpaceL ), 0mm), x_size=patchW, y_size=patchL)
  patch4 = rectangle(corner=(-patchW/2, 3*(patchL + arraySpaceL), 0mm), x_size=patchW, y_size=patchL)
  QWTtrace = rectangle(corner=(-qwtWidth/2, -arraySpaceL, 0mm), x_size=qwtWidth, y_size=4*patchL + 4*arraySpaceL)
  column1 = rectangle(corner=(-fiftyOhmW/2, -5mm - arraySpaceL, 0mm), x_size=fiftyOhmW, y_size=5mm)
  column1.unite(QWTtrace, patch1..patch4)
  Rectangle1 = rectangle(corner=(-fiftyOhmW/2, -(arraySpaceL + 5mm), -subZ), z_size=subZ, x_size=fiftyOhmW)
  RadiatingSurface [vacuum] = region(absolute_offset=3.5714286mm on all sides)
  coordinate_system RelativeCS1 = origin=(0mm, 0mm, 0mm) x=(1mm, 0mm, 0mm) y=(0mm, 1mm, 0mm)
  column2 = rectangle(corner=(-fiftyOhmW/2+1*2*antennaSpacing, -5mm - arraySpaceL, 0mm), x_size=fiftyOhmW, y_size=5mm) in RelativeCS1
  QWTtrace1 = rectangle(corner=(-qwtWidth/2+1*2*antennaSpacing, -arraySpaceL, 0mm), x_size=qwtWidth, y_size=4*patchL + 4*arraySpaceL) in RelativeCS1
  patch5 = rectangle(corner=(-patchW/2+1*2*antennaSpacing, 0mm, 0mm), x_size=patchW, y_size=patchL) in RelativeCS1
  patch6 = rectangle(corner=(-patchW/2+1*2*antennaSpacing, 1 * (patchL + arraySpaceL), 0mm), x_size=patchW, y_size=patchL) in RelativeCS1
  patch7 = rectangle(corner=(-patchW/2+1*2*antennaSpacing, 2*(patchL + arraySpaceL ), 0mm), x_size=patchW, y_size=patchL) in RelativeCS1
  patch8 = rectangle(corner=(-patchW/2 +1*2*antennaSpacing, 3*(patchL + arraySpaceL), 0mm), x_size=patchW, y_size=patchL) in RelativeCS1
  column2.unite(QWTtrace1, patch5..patch8)
  column3 = rectangle(corner=(-fiftyOhmW/2+2*2*antennaSpacing, -5mm - arraySpaceL, 0mm), x_size=fiftyOhmW, y_size=5mm) in RelativeCS1
  QWTtrace2 = rectangle(corner=(-qwtWidth/2+2*2*antennaSpacing, -arraySpaceL, 0mm), x_size=qwtWidth, y_size=4*patchL + 4*arraySpaceL) in RelativeCS1
  patch9 = rectangle(corner=(-patchW/2+2*2*antennaSpacing, 0mm, 0mm), x_size=patchW, y_size=patchL) in RelativeCS1
  patch10 = rectangle(corner=(-patchW/2+2*2*antennaSpacing, 1 * (patchL + arraySpaceL), 0mm), x_size=patchW, y_size=patchL) in RelativeCS1
  patch11 = rectangle(corner=(-patchW/2 +2*2*antennaSpacing, 2*(patchL + arraySpaceL ), 0mm), x_size=patchW, y_size=patchL) in RelativeCS1
  patch12 = rectangle(corner=(-patchW/2 +2*2*antennaSpacing, 3*(patchL + arraySpaceL), 0mm), x_size=patchW, y_size=patchL) in RelativeCS1
  column3.unite(QWTtrace2, patch9..patch12)
  column4 = rectangle(corner=(-fiftyOhmW/2+3*2*antennaSpacing, -5mm - arraySpaceL, 0mm), x_size=fiftyOhmW, y_size=5mm)
  QWTtrace3 = rectangle(corner=(-qwtWidth/2+3*2*antennaSpacing, -arraySpaceL, 0mm), x_size=qwtWidth, y_size=4*patchL + 4*arraySpaceL)
  patch13 = rectangle(corner=(-patchW/2+3*2*antennaSpacing, 0mm, 0mm), x_size=patchW, y_size=patchL)
  patch14 = rectangle(corner=(-patchW/2+3*2*antennaSpacing, 1 * (patchL + arraySpaceL), 0mm), x_size=patchW, y_size=patchL)
  patch15 = rectangle(corner=(-patchW/2 +3*2*antennaSpacing, 2*(patchL + arraySpaceL ), 0mm), x_size=patchW, y_size=patchL)
  patch16 = rectangle(corner=(-patchW/2 +3*2*antennaSpacing, 3*(patchL + arraySpaceL), 0mm), x_size=patchW, y_size=patchL)
  column4.unite(QWTtrace3, patch13..patch16)
  port1 = rectangle(corner=(-fiftyOhmW/2, -7.65mm, -subZ), z_size=subZ, x_size=fiftyOhmW)
  port2 = rectangle(corner=(-fiftyOhmW/2+1*2*antennaSpacing, -7.65mm, -subZ), z_size=subZ, x_size=fiftyOhmW)
  port3 = rectangle(corner=(-fiftyOhmW/2+2*2*antennaSpacing, -7.65mm, -subZ), z_size=subZ, x_size=fiftyOhmW)
  port4 = rectangle(corner=(-fiftyOhmW/2+3*2*antennaSpacing, -7.65mm, -subZ), z_size=subZ, x_size=fiftyOhmW)
  coordinate_system RelativeCS2 = origin=(9.5mm, 9.5mm, 0mm) x=(1mm, 0mm, 0mm) y=(0mm, 1mm, 0mm)
boundaries and excitations:
  ground: Perfect E Faces=substrate.face(-z)
  Open1: Radiation Objects=RadiatingSurface
  goldTrace: Finite Conductivity Objects=[column1..column4] Conductivity=41100000 Permeability=1 IsInternal
  p1: Lumped Port Objects=port1 Modes{Mode1{IntLine{middle of port1.edge(z opposite corner) -> middle of port1.edge(z at corner)} CharImp=Zpi RenormImp=50ohm}} Impedance=50ohm
  p2: Lumped Port Objects=port2 Modes{Mode1{IntLine{middle of port2.edge(z opposite corner) -> middle of port2.edge(z at corner)} CharImp=Zpi RenormImp=50ohm}} Impedance=50ohm
  p3: Lumped Port Objects=port3 Modes{Mode1{IntLine{middle of port3.edge(z opposite corner) -> middle of port3.edge(z at corner)} CharImp=Zpi RenormImp=50ohm}} Impedance=50ohm
  p4: Lumped Port Objects=port4 Modes{Mode1{IntLine{middle of port4.edge(z opposite corner) -> middle of port4.edge(z at corner)} CharImp=Zpi RenormImp=50ohm}} Impedance=50ohm
setups:
  Setup1: HfssDriven Frequency=28GHz MaxDeltaS=0.02 MaximumPasses=6 MinimumPasses=1 MinimumConvergedPasses=1 PercentRefinement=30 BasisOrder=0 PortAccuracy=2
    sweep Sweep: 20GHz to 36GHz, 401 points; Type=Interpolating InterpTolerance=0.2 InterpMaxSolns=250 InterpUsePortImped=false PassivityErrorTolerance=0.0001
source amplitudes:
  p1:1, p4:1: 1W -30deg
  p2:1, p3:1: 1W -15deg
optimetrics:
  ParametricSetup1: Parametric Sim._Setups=[Setup1]
    sweep dt: LIN 0deg 360deg 10deg
radiation setups:
  3D: Infinite Sphere Theta=0deg..180deg step 2deg Phi=-180deg..180deg step 2deg
  Elevation: Infinite Sphere Theta=-180deg..180deg step 1deg Phi=0deg..90deg step 90deg
  Azimuth: Infinite Sphere Theta=90deg..90deg step 0deg Phi=-180deg..180deg step 1deg
  ff_2d: Infinite Sphere Theta=-180deg..180deg step 2deg Phi=0deg..90deg step 90deg
  Infinite Sphere1: Infinite Sphere Theta=0deg..180deg step 2deg Phi=0deg..360deg step 2deg CoordSystem=RelativeCS2
reports:
  Full-Array Gain Plot: dB(GainTotal) vs Phi, Theta on Setup1 : LastAdaptive, Infinite Sphere1 [Freq=28GHz]
  Gain Plot 3: dB(GainTotal) vs Theta on Setup1 : LastAdaptive, ff_2d [Phi=all Freq=28GHz]; markers m1 at 0deg
  Directivity Plot 1: dB(DirTotal) vs Phi, Theta on Setup1 : LastAdaptive, 3D [Freq=28GHz dt=0deg]
  Directivity Plot 2: dB(DirTotal) vs Theta on Setup1 : LastAdaptive, ff_2d [Phi=all Freq=28GHz dt=all]; markers m1 at 0deg, m2 at 24deg
  Gain Plot 4: dB(GainTotal) vs Theta on Setup1 : LastAdaptive, ff_2d [Phi=all Freq=28GHz dt=all]

design phasing (HFSS, DrivenModal, model units mm)
variables:
  subX = 32mm
  subY = 40mm
  subZ = 0.3mm
  patchW = 3.25mm
  patchL = 2.85mm
  arraySpaceL = 2.65mm
  qwtWidth = 0.3mm
  fiftyOhmW = 0.85mm
  antennaSpacing = (6.25/2) mm
  dt = 0deg
geometry:
  substrate [Arlon AD410 (tm)] = box(corner=(-6mm, -15mm, -subZ), size=(subX, subY, subZ))
  patch1 = rectangle(corner=(-patchW/2, 0mm, 0mm), x_size=patchW, y_size=patchL)
  patch2 = rectangle(corner=(-patchW/2, 1 * (patchL + arraySpaceL), 0mm), x_size=patchW, y_size=patchL)
  patch3 = rectangle(corner=(-patchW/2, 2*(patchL + arraySpaceL ), 0mm), x_size=patchW, y_size=patchL)
  patch4 = rectangle(corner=(-patchW/2, 3*(patchL + arraySpaceL), 0mm), x_size=patchW, y_size=patchL)
  QWTtrace = rectangle(corner=(-qwtWidth/2, -arraySpaceL, 0mm), x_size=qwtWidth, y_size=4*patchL + 4*arraySpaceL)
  column1 = rectangle(corner=(-fiftyOhmW/2, -5mm - arraySpaceL, 0mm), x_size=fiftyOhmW, y_size=5mm)
  column1.unite(QWTtrace, patch1..patch4)
  Rectangle1 = rectangle(corner=(-fiftyOhmW/2, -(arraySpaceL + 5mm), -subZ), z_size=subZ, x_size=fiftyOhmW)
  RadiatingSurface [vacuum] = region(absolute_offset=3.5714286mm on all sides)
  coordinate_system RelativeCS1 = origin=(0mm, 0mm, 0mm) x=(1mm, 0mm, 0mm) y=(0mm, 1mm, 0mm)
  column2 = rectangle(corner=(-fiftyOhmW/2+1*2*antennaSpacing, -5mm - arraySpaceL, 0mm), x_size=fiftyOhmW, y_size=5mm) in RelativeCS1
  QWTtrace1 = rectangle(corner=(-qwtWidth/2+1*2*antennaSpacing, -arraySpaceL, 0mm), x_size=qwtWidth, y_size=4*patchL + 4*arraySpaceL) in RelativeCS1
  patch5 = rectangle(corner=(-patchW/2+1*2*antennaSpacing, 0mm, 0mm), x_size=patchW, y_size=patchL) in RelativeCS1
  patch6 = rectangle(corner=(-patchW/2+1*2*antennaSpacing, 1 * (patchL + arraySpaceL), 0mm), x_size=patchW, y_size=patchL) in RelativeCS1
  patch7 = rectangle(corner=(-patchW/2+1*2*antennaSpacing, 2*(patchL + arraySpaceL ), 0mm), x_size=patchW, y_size=patchL) in RelativeCS1
  patch8 = rectangle(corner=(-patchW/2 +1*2*antennaSpacing, 3*(patchL + arraySpaceL), 0mm), x_size=patchW, y_size=patchL) in RelativeCS1
  column2.unite(QWTtrace1, patch5..patch8)
  column3 = rectangle(corner=(-fiftyOhmW/2+2*2*antennaSpacing, -5mm - arraySpaceL, 0mm), x_size=fiftyOhmW, y_size=5mm) in RelativeCS1
  QWTtrace2 = rectangle(corner=(-qwtWidth/2+2*2*antennaSpacing, -arraySpaceL, 0mm), x_size=qwtWidth, y_size=4*patchL + 4*arraySpaceL) in RelativeCS1
  patch9 = rectangle(corner=(-patchW/2+2*2*antennaSpacing, 0mm, 0mm), x_size=patchW, y_size=patchL) in RelativeCS1
  patch10 = rectangle(corner=(-patchW/2+2*2*antennaSpacing, 1 * (patchL + arraySpaceL), 0mm), x_size=patchW, y_size=patchL) in RelativeCS1
  patch11 = rectangle(corner=(-patchW/2 +2*2*antennaSpacing, 2*(patchL + arraySpaceL ), 0mm), x_size=patchW, y_size=patchL) in RelativeCS1
  patch12 = rectangle(corner=(-patchW/2 +2*2*antennaSpacing, 3*(patchL + arraySpaceL), 0mm), x_size=patchW, y_size=patchL) in RelativeCS1
  column3.unite(QWTtrace2, patch9..patch12)
  column4 = rectangle(corner=(-fiftyOhmW/2+3*2*antennaSpacing, -5mm - arraySpaceL, 0mm), x_size=fiftyOhmW, y_size=5mm)
  QWTtrace3 = rectangle(corner=(-qwtWidth/2+3*2*antennaSpacing, -arraySpaceL, 0mm), x_size=qwtWidth, y_size=4*patchL + 4*arraySpaceL)
  patch13 = rectangle(corner=(-patchW/2+3*2*antennaSpacing, 0mm, 0mm), x_size=patchW, y_size=patchL)
  patch14 = rectangle(corner=(-patchW/2+3*2*antennaSpacing, 1 * (patchL + arraySpaceL), 0mm), x_size=patchW, y_size=patchL)
  patch15 = rectangle(corner=(-patchW/2 +3*2*antennaSpacing, 2*(patchL + arraySpaceL ), 0mm), x_size=patchW, y_size=patchL)
  patch16 = rectangle(corner=(-patchW/2 +3*2*antennaSpacing, 3*(patchL + arraySpaceL), 0mm), x_size=patchW, y_size=patchL)
  column4.unite(QWTtrace3, patch13..patch16)
  port1 = rectangle(corner=(-fiftyOhmW/2, -7.65mm, -subZ), z_size=subZ, x_size=fiftyOhmW)
  port2 = rectangle(corner=(-fiftyOhmW/2+1*2*antennaSpacing, -7.65mm, -subZ), z_size=subZ, x_size=fiftyOhmW)
  port3 = rectangle(corner=(-fiftyOhmW/2+2*2*antennaSpacing, -7.65mm, -subZ), z_size=subZ, x_size=fiftyOhmW)
  port4 = rectangle(corner=(-fiftyOhmW/2+3*2*antennaSpacing, -7.65mm, -subZ), z_size=subZ, x_size=fiftyOhmW)
  coordinate_system RelativeCS2 = origin=(9.6mm, 9.6mm, 0mm) x=(1mm, 0mm, 0mm) y=(0mm, 1mm, 0mm)
boundaries and excitations:
  Open1: Radiation Objects=RadiatingSurface
  goldTrace: Finite Conductivity Objects=[column1..column4] Conductivity=41100000 Permeability=1 IsInternal
  ground: Perfect E Faces=substrate.face(-z)
  p1: Lumped Port Objects=port1 Modes{Mode1{IntLine{middle of port1.edge(z opposite corner) -> middle of port1.edge(z at corner)} CharImp=Zpi RenormImp=50ohm}} Impedance=50ohm
  p2: Lumped Port Objects=port2 Modes{Mode1{IntLine{middle of port2.edge(z opposite corner) -> middle of port2.edge(z at corner)} CharImp=Zpi RenormImp=50ohm}} Impedance=50ohm
  p3: Lumped Port Objects=port3 Modes{Mode1{IntLine{middle of port3.edge(z opposite corner) -> middle of port3.edge(z at corner)} CharImp=Zpi RenormImp=50ohm}} Impedance=50ohm
  p4: Lumped Port Objects=port4 Modes{Mode1{IntLine{middle of port4.edge(z opposite corner) -> middle of port4.edge(z at corner)} CharImp=Zpi RenormImp=50ohm}} Impedance=50ohm
setups:
  Setup1: HfssDriven Frequency=28GHz MaxDeltaS=0.02 MaximumPasses=6 MinimumPasses=1 MinimumConvergedPasses=1 PercentRefinement=30 BasisOrder=0 PortAccuracy=2
    sweep Sweep: 20GHz to 36GHz, 401 points; Type=Interpolating InterpTolerance=0.2 InterpMaxSolns=250 InterpUsePortImped=false PassivityErrorTolerance=0.0001
source amplitudes:
  p1:1: 1W 0deg
  p2:1: 1W 1*dt
  p3:1: 1W 2*dt
  p4:1: 1W 3*dt
optimetrics:
  ParametricSetup1: Parametric Sim._Setups=[Setup1]
    sweep dt: LIN -90deg 90deg 2deg
radiation setups:
  3D: Infinite Sphere Theta=0deg..180deg step 2deg Phi=-180deg..180deg step 2deg
  Elevation: Infinite Sphere Theta=-180deg..180deg step 1deg Phi=0deg..90deg step 90deg
  Azimuth: Infinite Sphere Theta=90deg..90deg step 0deg Phi=-180deg..180deg step 1deg
  ff_2d: Infinite Sphere Theta=-180deg..180deg step 2deg Phi=0deg..90deg step 90deg
  Infinite Sphere1: Infinite Sphere Theta=0deg..180deg step 2deg Phi=0deg..360deg step 2deg
  center: Infinite Sphere Theta=0deg..180deg step 2deg Phi=0deg..360deg step 2deg CoordSystem=RelativeCS2
reports:
  Gain Plot 2: dB(GainTotal) vs Phi, Theta on Setup1 : LastAdaptive, Infinite Sphere1 [Freq=28GHz]
  Gain Plot 3: dB(GainTotal) vs Theta on Setup1 : LastAdaptive, ff_2d [Phi=all Freq=28GHz]; markers m1 at 0deg
  centerRadiation: dB(GainTotal) vs Phi, Theta on Setup1 : LastAdaptive, center [Freq=28GHz]
  Directivity Plot 1: dB(DirTotal) vs Theta on Setup1 : LastAdaptive, ff_2d [Phi=all Freq=28GHz dt=all]; markers m1 at 0deg, m2 at 24deg

design inlet (HFSS, DrivenModal, model units mm)
variables:
  subX = 32mm
  subY = 40mm
  subZ = 0.3mm
  patchW = 3.25mm
  patchL = 2.85mm
  arraySpaceL = 2.65mm
  qwtWidth = 0.3mm
  fiftyOhmW = 0.85mm
  antennaSpacing = (6.25/2) mm
  dt = 0deg
geometry:
  substrate [Arlon AD410 (tm)] = box(corner=(-6mm, -15mm, -subZ), size=(subX, subY, subZ))
  patch1 = rectangle(corner=(-patchW/2, 0mm, 0mm), x_size=patchW, y_size=patchL)
  patch2 = rectangle(corner=(-patchW/2, 1 * (patchL + arraySpaceL), 0mm), x_size=patchW, y_size=patchL)
  patch3 = rectangle(corner=(-patchW/2, 2*(patchL + arraySpaceL ), 0mm), x_size=patchW, y_size=patchL)
  patch4 = rectangle(corner=(-patchW/2, 3*(patchL + arraySpaceL), 0mm), x_size=patchW, y_size=patchL)
  QWTtrace = rectangle(corner=(-qwtWidth/2, -arraySpaceL, 0mm), x_size=qwtWidth, y_size=4*patchL + 4*arraySpaceL)
  column1 = rectangle(corner=(-fiftyOhmW/2, -5mm - arraySpaceL, 0mm), x_size=fiftyOhmW, y_size=5mm)
  column1.unite(QWTtrace, patch1..patch4)
  Rectangle1 = rectangle(corner=(-fiftyOhmW/2, -(arraySpaceL + 5mm), -subZ), z_size=subZ, x_size=fiftyOhmW)
  RadiatingSurface [vacuum] = region(absolute_offset=3.5714286mm on all sides)
  coordinate_system RelativeCS1 = origin=(0mm, 0mm, 0mm) x=(1mm, 0mm, 0mm) y=(0mm, 1mm, 0mm)
  column2 = rectangle(corner=(-fiftyOhmW/2+1*2*antennaSpacing, -5mm - arraySpaceL, 0mm), x_size=fiftyOhmW, y_size=5mm) in RelativeCS1
  QWTtrace1 = rectangle(corner=(-qwtWidth/2+1*2*antennaSpacing, -arraySpaceL, 0mm), x_size=qwtWidth, y_size=4*patchL + 4*arraySpaceL) in RelativeCS1
  patch5 = rectangle(corner=(-patchW/2+1*2*antennaSpacing, 0mm, 0mm), x_size=patchW, y_size=patchL) in RelativeCS1
  patch6 = rectangle(corner=(-patchW/2+1*2*antennaSpacing, 1 * (patchL + arraySpaceL), 0mm), x_size=patchW, y_size=patchL) in RelativeCS1
  patch7 = rectangle(corner=(-patchW/2+1*2*antennaSpacing, 2*(patchL + arraySpaceL ), 0mm), x_size=patchW, y_size=patchL) in RelativeCS1
  patch8 = rectangle(corner=(-patchW/2 +1*2*antennaSpacing, 3*(patchL + arraySpaceL), 0mm), x_size=patchW, y_size=patchL) in RelativeCS1
  column2.unite(QWTtrace1, patch5..patch8)
  column3 = rectangle(corner=(-fiftyOhmW/2+2*2*antennaSpacing, -5mm - arraySpaceL, 0mm), x_size=fiftyOhmW, y_size=5mm) in RelativeCS1
  QWTtrace2 = rectangle(corner=(-qwtWidth/2+2*2*antennaSpacing, -arraySpaceL, 0mm), x_size=qwtWidth, y_size=4*patchL + 4*arraySpaceL) in RelativeCS1
  patch9 = rectangle(corner=(-patchW/2+2*2*antennaSpacing, 0mm, 0mm), x_size=patchW, y_size=patchL) in RelativeCS1
  patch10 = rectangle(corner=(-patchW/2+2*2*antennaSpacing, 1 * (patchL + arraySpaceL), 0mm), x_size=patchW, y_size=patchL) in RelativeCS1
  patch11 = rectangle(corner=(-patchW/2 +2*2*antennaSpacing, 2*(patchL + arraySpaceL ), 0mm), x_size=patchW, y_size=patchL) in RelativeCS1
  patch12 = rectangle(corner=(-patchW/2 +2*2*antennaSpacing, 3*(patchL + arraySpaceL), 0mm), x_size=patchW, y_size=patchL) in RelativeCS1
  column3.unite(QWTtrace2, patch9..patch12)
  column4 = rectangle(corner=(-fiftyOhmW/2+3*2*antennaSpacing, -5mm - arraySpaceL, 0mm), x_size=fiftyOhmW, y_size=5mm)
  QWTtrace3 = rectangle(corner=(-qwtWidth/2+3*2*antennaSpacing, -arraySpaceL, 0mm), x_size=qwtWidth, y_size=4*patchL + 4*arraySpaceL)
  patch13 = rectangle(corner=(-patchW/2+3*2*antennaSpacing, 0mm, 0mm), x_size=patchW, y_size=patchL)
  patch14 = rectangle(corner=(-patchW/2+3*2*antennaSpacing, 1 * (patchL + arraySpaceL), 0mm), x_size=patchW, y_size=patchL)
  patch15 = rectangle(corner=(-patchW/2 +3*2*antennaSpacing, 2*(patchL + arraySpaceL ), 0mm), x_size=patchW, y_size=patchL)
  patch16 = rectangle(corner=(-patchW/2 +3*2*antennaSpacing, 3*(patchL + arraySpaceL), 0mm), x_size=patchW, y_size=patchL)
  column4.unite(QWTtrace3, patch13..patch16)
  port1 = rectangle(corner=(-fiftyOhmW/2, -7.65mm, -subZ), z_size=subZ, x_size=fiftyOhmW)
  port2 = rectangle(corner=(-fiftyOhmW/2+1*2*antennaSpacing, -7.65mm, -subZ), z_size=subZ, x_size=fiftyOhmW)
  port3 = rectangle(corner=(-fiftyOhmW/2+2*2*antennaSpacing, -7.65mm, -subZ), z_size=subZ, x_size=fiftyOhmW)
  port4 = rectangle(corner=(-fiftyOhmW/2+3*2*antennaSpacing, -7.65mm, -subZ), z_size=subZ, x_size=fiftyOhmW)
  coordinate_system RelativeCS2 = origin=(9.6mm, 9.6mm, 0mm) x=(1mm, 0mm, 0mm) y=(0mm, 1mm, 0mm)
boundaries and excitations:
  ground: Perfect E Faces=substrate.face(-z)
  Open1: Radiation Objects=RadiatingSurface
  goldTrace: Finite Conductivity Objects=[column1..column4] Conductivity=41100000 Permeability=1 IsInternal
  p1: Lumped Port Objects=port1 Modes{Mode1{IntLine{middle of port1.edge(z opposite corner) -> middle of port1.edge(z at corner)} CharImp=Zpi RenormImp=50ohm}} Impedance=50ohm
  p2: Lumped Port Objects=port2 Modes{Mode1{IntLine{middle of port2.edge(z opposite corner) -> middle of port2.edge(z at corner)} CharImp=Zpi RenormImp=50ohm}} Impedance=50ohm
  p3: Lumped Port Objects=port3 Modes{Mode1{IntLine{middle of port3.edge(z opposite corner) -> middle of port3.edge(z at corner)} CharImp=Zpi RenormImp=50ohm}} Impedance=50ohm
  p4: Lumped Port Objects=port4 Modes{Mode1{IntLine{middle of port4.edge(z opposite corner) -> middle of port4.edge(z at corner)} CharImp=Zpi RenormImp=50ohm}} Impedance=50ohm
setups:
  Setup1: HfssDriven Frequency=28GHz MaxDeltaS=0.02 MaximumPasses=6 MinimumPasses=1 MinimumConvergedPasses=1 PercentRefinement=30 BasisOrder=0 PortAccuracy=2
    sweep Sweep: 20GHz to 36GHz, 401 points; Type=Interpolating InterpTolerance=0.2 InterpMaxSolns=250 InterpUsePortImped=false PassivityErrorTolerance=0.0001
source amplitudes:
  p1:1: 1W 0deg
  p2:1: 1W 1*dt
  p3:1: 1W 2*dt
  p4:1: 1W 3*dt
optimetrics:
  ParametricSetup1: Parametric Sim._Setups=[Setup1]
    sweep dt: LIN -90deg 90deg 2deg
radiation setups:
  3D: Infinite Sphere Theta=0deg..180deg step 2deg Phi=-180deg..180deg step 2deg
  Elevation: Infinite Sphere Theta=-180deg..180deg step 1deg Phi=0deg..90deg step 90deg
  Azimuth: Infinite Sphere Theta=90deg..90deg step 0deg Phi=-180deg..180deg step 1deg
  ff_2d: Infinite Sphere Theta=-180deg..180deg step 2deg Phi=0deg..90deg step 90deg
  Infinite Sphere1: Infinite Sphere Theta=0deg..180deg step 2deg Phi=0deg..360deg step 2deg
  center: Infinite Sphere Theta=0deg..180deg step 2deg Phi=0deg..360deg step 2deg CoordSystem=RelativeCS2
reports:
  Gain Plot 2: dB(GainTotal) vs Phi, Theta on Setup1 : LastAdaptive, Infinite Sphere1 [Freq=28GHz]
  Gain Plot 3: dB(GainTotal) vs Theta on Setup1 : LastAdaptive, ff_2d [Phi=all Freq=28GHz]; markers m1 at 0deg
  centerRadiation: dB(GainTotal) vs Phi, Theta on Setup1 : LastAdaptive, center [Freq=28GHz]
  Directivity Plot 1: dB(DirTotal) vs Theta on Setup1 : LastAdaptive, ff_2d [Phi=all Freq=28GHz dt=all]; markers m1 at 0deg, m2 at 24deg

design 2_2_singlecolumn_inlet (HFSS, DrivenModal, model units mm)
variables:
  subX = 25mm
  subY = 50mm
  subZ = 0.3mm
  patchW = 3.25mm
  patchL = 2.85mm
  arraySpaceL = 2.65mm
  qwtWidth = 0.3mm
  fiftyOhmW = 0.85mm
geometry:
  substrate [Arlon AD410 (tm)] = box(corner=(-subX/2, -subY/2, -subZ), size=(subX, subY, subZ))
  patch1 = rectangle(corner=(-patchW/2, 0mm, 0mm), x_size=patchW, y_size=patchL)
  patch2 = rectangle(corner=(-patchW/2, 1 * (patchL + arraySpaceL), 0mm), x_size=patchW, y_size=patchL)
  patch3 = rectangle(corner=(-patchW/2, 2*(patchL + arraySpaceL ), 0mm), x_size=patchW, y_size=patchL)
  patch4 = rectangle(corner=(-patchW/2, 3*(patchL + arraySpaceL), 0mm), x_size=patchW, y_size=patchL)
  QWTtrace = rectangle(corner=(-qwtWidth/2, -arraySpaceL, 0mm), x_size=qwtWidth, y_size=4*patchL + 4*arraySpaceL)
  50ohm = rectangle(corner=(-fiftyOhmW/2, -5mm - arraySpaceL, 0mm), x_size=fiftyOhmW, y_size=5mm)
  Rectangle1 = rectangle(corner=(-fiftyOhmW/2, -(arraySpaceL + 5mm), -subZ), z_size=subZ, x_size=fiftyOhmW)
  RadiatingSurface [vacuum] = region(absolute_offset=3.5714286mm on all sides)
  inlet1_1 = rectangle(corner=(-qwtWidth, 0mm, 0mm), x_size=qwtWidth*2, y_size=patchL/4)
  inlet1_2 = rectangle(corner=(-qwtWidth, 3*patchL/4, 0mm), x_size=qwtWidth*2, y_size=patchL/4)
  inlet2_1 = rectangle(corner=(-qwtWidth, 1 * (patchL + arraySpaceL), 0mm), x_size=qwtWidth*2, y_size=patchL/4)
  inlet2_2 = rectangle(corner=(-qwtWidth, 1*(patchL + arraySpaceL)+(3*patchL/4), 0mm), x_size=qwtWidth*2, y_size=patchL/4)
  inlet3_1 = rectangle(corner=(-qwtWidth, 2 * (patchL + arraySpaceL), 0mm), x_size=qwtWidth*2, y_size=patchL/4)
  inlet3_2 = rectangle(corner=(-qwtWidth, 2*(patchL + arraySpaceL)+(3*patchL/4), 0mm), x_size=qwtWidth*2, y_size=patchL/4)
  inlet4_1 = rectangle(corner=(-qwtWidth, 3 * (patchL + arraySpaceL), 0mm), x_size=qwtWidth*2, y_size=patchL/4)
  inlet4_2 = rectangle(corner=(-qwtWidth, 3*(patchL + arraySpaceL)+(3*patchL/4), 0mm), x_size=qwtWidth*2, y_size=patchL/4)
  inlet1_1.unite(inlet1_2)
  inlet2_1.unite(inlet2_2)
  inlet3_1.unite(inlet3_2)
  inlet4_1.unite(inlet4_2)
  patch1.subtract(inlet1_1)
  patch2.subtract(inlet2_1)
  patch3.subtract(inlet3_1)
  patch4.subtract(inlet4_1)
  50ohm.unite(patch1..patch4, QWTtrace)
  coordinate_system RelativeCS1 = origin=(0mm, 9.4mm, 0mm) x=(1mm, 0mm, 0mm) y=(0mm, 1mm, 0mm)
boundaries and excitations:
  ground: Perfect E Faces=substrate.face(-z)
  Open1: Radiation Objects=RadiatingSurface
  traceAu: Finite Conductivity Objects=50ohm Conductivity=41100000 Permeability=1 IsInternal
  port1: Lumped Port Objects=Rectangle1 Modes{Mode1{IntLine{middle of Rectangle1.edge(z opposite corner) -> middle of Rectangle1.edge(z at corner)} CharImp=Zpi RenormImp=50ohm}} Impedance=50ohm
setups:
  Setup1: HfssDriven Frequency=28GHz MaxDeltaS=0.02 MaximumPasses=6 MinimumPasses=1 MinimumConvergedPasses=1 PercentRefinement=30 BasisOrder=0 PortAccuracy=2
    sweep Sweep: 20GHz to 36GHz, 401 points; Type=Interpolating InterpTolerance=0.2 InterpMaxSolns=250 InterpUsePortImped=false PassivityErrorTolerance=0.0001
source amplitudes:
  port1:1: 1W 0deg
radiation setups:
  3D: Infinite Sphere Theta=0deg..180deg step 2deg Phi=-180deg..180deg step 2deg
  Elevation: Infinite Sphere Theta=-180deg..180deg step 1deg Phi=0deg..90deg step 90deg
  Azimuth: Infinite Sphere Theta=90deg..90deg step 0deg Phi=-180deg..180deg step 1deg
  ff_2d: Infinite Sphere Theta=-180deg..180deg step 2deg Phi=0deg..90deg step 90deg
  Infinite Sphere1: Infinite Sphere Theta=0deg..180deg step 2deg Phi=0deg..360deg step 2deg
  coord: Infinite Sphere Theta=0deg..180deg step 2deg Phi=0deg..360deg step 2deg CoordSystem=RelativeCS1
reports:
  Gain Plot 1: dB(GainTotal) vs Phi, Theta on Setup1 : LastAdaptive, 3D [Freq=28GHz]
  Gain Plot 1_1: dB(GainTotal) vs Phi, Theta on Setup1 : LastAdaptive, 3D [Freq=28GHz]
  Gain Plot 2: dB(GainTotal) vs Phi, Theta on Setup1 : LastAdaptive, coord [Freq=28GHz]

design 3_1_inletArray (HFSS, DrivenModal, model units mm)
variables:
  subX = (25*2) mm
  subY = 50mm
  subZ = 0.3mm
  patchW = 3.25mm
  patchL = 2.85mm
  arraySpaceL = 2.65mm
  qwtWidth = 0.3mm
  fiftyOhmW = 0.85mm
geometry:
  substrate [Arlon AD410 (tm)] = box(corner=(-subX/2+10mm, -subY/2, -subZ), size=(subX, subY, subZ))
  patch1 = rectangle(corner=(-patchW/2, 0mm, 0mm), x_size=patchW, y_size=patchL)
  patch2 = rectangle(corner=(-patchW/2, 1 * (patchL + arraySpaceL), 0mm), x_size=patchW, y_size=patchL)
  patch3 = rectangle(corner=(-patchW/2, 2*(patchL + arraySpaceL ), 0mm), x_size=patchW, y_size=patchL)
  patch4 = rectangle(corner=(-patchW/2, 3*(patchL + arraySpaceL), 0mm), x_size=patchW, y_size=patchL)
  QWTtrace = rectangle(corner=(-qwtWidth/2, -arraySpaceL, 0mm), x_size=qwtWidth, y_size=4*patchL + 4*arraySpaceL)
  50ohm = rectangle(corner=(-fiftyOhmW/2, -5mm - arraySpaceL, 0mm), x_size=fiftyOhmW, y_size=5mm)
  Rectangle1 = rectangle(corner=(-fiftyOhmW/2, -(arraySpaceL + 5mm), -subZ), z_size=subZ, x_size=fiftyOhmW)
  RadiatingSurface [vacuum] = region(absolute_offset=3.5714286mm on all sides)
  inlet1_1 = rectangle(corner=(-qwtWidth, 0mm, 0mm), x_size=qwtWidth*2, y_size=patchL/4)
  inlet1_2 = rectangle(corner=(-qwtWidth, 3*patchL/4, 0mm), x_size=qwtWidth*2, y_size=patchL/4)
  inlet2_1 = rectangle(corner=(-qwtWidth, 1 * (patchL + arraySpaceL), 0mm), x_size=qwtWidth*2, y_size=patchL/4)
  inlet2_2 = rectangle(corner=(-qwtWidth, 1*(patchL + arraySpaceL)+(3*patchL/4), 0mm), x_size=qwtWidth*2, y_size=patchL/4)
  inlet3_1 = rectangle(corner=(-qwtWidth, 2 * (patchL + arraySpaceL), 0mm), x_size=qwtWidth*2, y_size=patchL/4)
  inlet3_2 = rectangle(corner=(-qwtWidth, 2*(patchL + arraySpaceL)+(3*patchL/4), 0mm), x_size=qwtWidth*2, y_size=patchL/4)
  inlet4_1 = rectangle(corner=(-qwtWidth, 3 * (patchL + arraySpaceL), 0mm), x_size=qwtWidth*2, y_size=patchL/4)
  inlet4_2 = rectangle(corner=(-qwtWidth, 3*(patchL + arraySpaceL)+(3*patchL/4), 0mm), x_size=qwtWidth*2, y_size=patchL/4)
  inlet1_1.unite(inlet1_2)
  inlet2_1.unite(inlet2_2)
  inlet3_1.unite(inlet3_2)
  inlet4_1.unite(inlet4_2)
  patch1.subtract(inlet1_1)
  patch2.subtract(inlet2_1)
  patch3.subtract(inlet3_1)
  patch4.subtract(inlet4_1)
  50ohm.unite(patch1..patch4, QWTtrace)
  coordinate_system RelativeCS1 = origin=(0mm, 9.4mm, 0mm) x=(1mm, 0mm, 0mm) y=(0mm, 1mm, 0mm)
  Rectangle2 = rectangle(corner=(-fiftyOhmW/2 + 1*6.4mm, -(arraySpaceL + 5mm), -subZ), z_size=subZ, x_size=fiftyOhmW)
  Rectangle3 = rectangle(corner=(-fiftyOhmW/2 + 2*6.4mm, -(arraySpaceL + 5mm), -subZ), z_size=subZ, x_size=fiftyOhmW)
  Rectangle4 = rectangle(corner=(-fiftyOhmW/2 + 3*6.4mm, -(arraySpaceL + 5mm), -subZ), z_size=subZ, x_size=fiftyOhmW)
  coordinate_system RelativeCS2 = origin=(9.6mm, 0mm, 0mm) x=(1mm, 0mm, 0mm) y=(0mm, 1mm, 0mm) in RelativeCS1
  50ohm_1, 50ohm_2, 50ohm_3 = 50ohm.duplicate_along_line(step=(6.4mm, 0mm, 0mm), total=4)
boundaries and excitations:
  ground: Perfect E Faces=substrate.face(-z)
  Open1: Radiation Objects=RadiatingSurface
  traceAu: Finite Conductivity Objects=[50ohm_3, 50ohm_2, 50ohm_1, 50ohm] Conductivity=41100000 Permeability=1 IsInternal
  port1: Lumped Port Objects=Rectangle1 Modes{Mode1{IntLine{middle of Rectangle1.edge(z opposite corner) -> middle of Rectangle1.edge(z at corner)} CharImp=Zpi RenormImp=50ohm}} Impedance=50ohm
  port2: Lumped Port Objects=Rectangle2 Modes{Mode1{IntLine{middle of Rectangle2.edge(z opposite corner) -> middle of Rectangle2.edge(z at corner)} CharImp=Zpi RenormImp=50ohm}} Impedance=50ohm
  port3: Lumped Port Objects=Rectangle3 Modes{Mode1{IntLine{middle of Rectangle3.edge(z opposite corner) -> middle of Rectangle3.edge(z at corner)} CharImp=Zpi RenormImp=50ohm}} Impedance=50ohm
  port4: Lumped Port Objects=Rectangle4 Modes{Mode1{IntLine{Rectangle4.edge(z opposite corner) at 0.476 along -> Rectangle4.edge(z at corner) at 0.524 along} CharImp=Zpi RenormImp=50ohm}} Impedance=50ohm
setups:
  Setup1: HfssDriven Frequency=28GHz MaxDeltaS=0.02 MaximumPasses=6 MinimumPasses=1 MinimumConvergedPasses=1 PercentRefinement=30 BasisOrder=0 PortAccuracy=2
    sweep Sweep: 20GHz to 36GHz, 401 points; Type=Interpolating InterpTolerance=0.2 InterpMaxSolns=250 InterpUsePortImped=false PassivityErrorTolerance=0.0001
source amplitudes:
  port1:1: 1W 0deg
  port2:1, port3:1, port4:1: 0W 0deg
radiation setups:
  3D: Infinite Sphere Theta=0deg..180deg step 2deg Phi=-180deg..180deg step 2deg
  Elevation: Infinite Sphere Theta=-180deg..180deg step 1deg Phi=0deg..90deg step 90deg
  Azimuth: Infinite Sphere Theta=90deg..90deg step 0deg Phi=-180deg..180deg step 1deg
  ff_2d: Infinite Sphere Theta=-180deg..180deg step 2deg Phi=0deg..90deg step 90deg
  Infinite Sphere1: Infinite Sphere Theta=0deg..180deg step 2deg Phi=0deg..360deg step 2deg CoordSystem=RelativeCS2
  coord: Infinite Sphere Theta=0deg..180deg step 2deg Phi=0deg..360deg step 2deg CoordSystem=RelativeCS2
reports:
  Gain Plot 1: dB(GainTotal) vs Phi, Theta on Setup1 : LastAdaptive, 3D [Freq=28GHz]
  Gain Plot 1_1: dB(GainTotal) vs Phi, Theta on Setup1 : LastAdaptive, 3D [Freq=28GHz]
  Gain Plot 2: dB(GainTotal) vs Phi, Theta on Setup1 : LastAdaptive, coord [Freq=28GHz]
  Directivity Plot 1: dB(DirTotal) vs Theta on Setup1 : LastAdaptive, ff_2d [Phi=all Freq=28GHz]

design 2_3_singlecolumn_inlet_AJUST (HFSS, DrivenModal, model units mm)
variables:
  subX = 25mm
  subY = 50mm
  subZ = 0.3mm
  patchW = 3.25mm
  patchL = 2.85mm
  arraySpaceL = 2.65mm
  qwtWidth = 0.3mm
  fiftyOhmW = 0.85mm
geometry:
  substrate [Arlon AD410 (tm)] = box(corner=(-subX/2, -subY/2, -subZ), size=(subX, subY, subZ))
  patch1 = rectangle(corner=(-patchW/2, 0mm, 0mm), x_size=patchW, y_size=patchL)
  patch2 = rectangle(corner=(-patchW/2, 1 * (patchL + arraySpaceL), 0mm), x_size=patchW, y_size=patchL)
  patch3 = rectangle(corner=(-patchW/2, 2*(patchL + arraySpaceL ), 0mm), x_size=patchW, y_size=patchL)
  patch4 = rectangle(corner=(-patchW/2, 3*(patchL + arraySpaceL), 0mm), x_size=patchW, y_size=patchL)
  QWTtrace = rectangle(corner=(-qwtWidth/2, -arraySpaceL, 0mm), x_size=qwtWidth, y_size=4*patchL + 4*arraySpaceL)
  50ohm = rectangle(corner=(-fiftyOhmW/2, -5mm - arraySpaceL, 0mm), x_size=fiftyOhmW, y_size=5mm)
  Rectangle1 = rectangle(corner=(-fiftyOhmW/2, -(arraySpaceL + 5mm), -subZ), z_size=subZ, x_size=fiftyOhmW)
  RadiatingSurface [vacuum] = region(absolute_offset=3.5714286mm on all sides)
  inlet1_1 = rectangle(corner=((-0.4/2) mm, 0mm, 0mm), x_size=0.4mm, y_size=0.8mm)
  inlet1_2 = rectangle(corner=(-0.4 mm/2, 3*patchL/4, 0mm), x_size=0.4mm, y_size=0.8mm)
  inlet2_1 = rectangle(corner=(-0.4mm/2, 1 * (patchL + arraySpaceL), 0mm), x_size=0.4mm, y_size=0.8mm)
  inlet2_2 = rectangle(corner=(-0.4mm/2, 1*(patchL + arraySpaceL)+(3*patchL/4), 0mm), x_size=0.4mm, y_size=0.8mm)
  inlet3_1 = rectangle(corner=(-0.4mm/2, 2 * (patchL + arraySpaceL), 0mm), x_size=0.4mm, y_size=0.8mm)
  inlet3_2 = rectangle(corner=(-0.4mm/2, 2*(patchL + arraySpaceL)+(3*patchL/4), 0mm), x_size=0.4mm, y_size=0.8mm)
  inlet4_1 = rectangle(corner=(-0.4mm/2, 3 * (patchL + arraySpaceL), 0mm), x_size=0.4mm, y_size=0.8mm)
  inlet4_2 = rectangle(corner=(-0.4mm/2, 3*(patchL + arraySpaceL)+(3*patchL/4), 0mm), x_size=0.4mm, y_size=0.8mm)
  inlet1_1.unite(inlet1_2)
  inlet2_1.unite(inlet2_2)
  inlet3_1.unite(inlet3_2)
  inlet4_1.unite(inlet4_2)
  patch1.subtract(inlet1_1)
  patch2.subtract(inlet2_1)
  patch3.subtract(inlet3_1)
  patch4.subtract(inlet4_1)
  50ohm.unite(patch1..patch4, QWTtrace)
  coordinate_system RelativeCS1 = origin=(0mm, 9.4mm, 0mm) x=(1mm, 0mm, 0mm) y=(0mm, 1mm, 0mm)
boundaries and excitations:
  ground: Perfect E Faces=substrate.face(-z)
  Open1: Radiation Objects=RadiatingSurface
  traceAu: Finite Conductivity Objects=50ohm Conductivity=41100000 Permeability=1 IsInternal
  port1: Lumped Port Objects=Rectangle1 Modes{Mode1{IntLine{middle of Rectangle1.edge(z opposite corner) -> middle of Rectangle1.edge(z at corner)} CharImp=Zpi RenormImp=50ohm}} Impedance=50ohm
setups:
  Setup1: HfssDriven Frequency=28GHz MaxDeltaS=0.02 MaximumPasses=6 MinimumPasses=1 MinimumConvergedPasses=1 PercentRefinement=30 BasisOrder=0 PortAccuracy=2
    sweep Sweep: 20GHz to 36GHz, 401 points; Type=Interpolating InterpTolerance=0.2 InterpMaxSolns=250 InterpUsePortImped=false PassivityErrorTolerance=0.0001
source amplitudes:
  port1:1: 0dBm 0deg
radiation setups:
  3D: Infinite Sphere Theta=0deg..180deg step 2deg Phi=-180deg..180deg step 2deg
  Elevation: Infinite Sphere Theta=-180deg..180deg step 1deg Phi=0deg..90deg step 90deg
  Azimuth: Infinite Sphere Theta=90deg..90deg step 0deg Phi=-180deg..180deg step 1deg
  ff_2d: Infinite Sphere Theta=-180deg..180deg step 2deg Phi=0deg..90deg step 90deg
  Infinite Sphere1: Infinite Sphere Theta=0deg..180deg step 2deg Phi=0deg..360deg step 2deg
  coord: Infinite Sphere Theta=0deg..180deg step 2deg Phi=0deg..360deg step 2deg CoordSystem=RelativeCS1
reports:
  Gain Plot 1: dB(GainTotal) vs Phi, Theta on Setup1 : LastAdaptive, 3D [Freq=28GHz]
  Gain Plot 1_1: dB(GainTotal) vs Phi, Theta on Setup1 : LastAdaptive, 3D [Freq=28GHz]
  Gain Plot 2: dB(GainTotal) vs Phi, Theta on Setup1 : LastAdaptive, coord [Freq=28GHz]
  Gain Plot 3: dB(GainTotal) vs Theta on Setup1 : LastAdaptive, ff_2d [Phi=all Freq=28GHz]; markers m1 at 2deg
  Directivity Plot 1: dB(DirTotal) vs Theta on Setup1 : LastAdaptive, ff_2d [Phi=all Freq=28GHz]

design 3_2_inletArrayAdjusted (HFSS, DrivenModal, model units mm)
variables:
  subX = (25*2) mm
  subY = 50mm
  subZ = 0.3mm
  patchW = 3.25mm
  patchL = 2.85mm
  arraySpaceL = 2.65mm
  qwtWidth = 0.3mm
  fiftyOhmW = 0.85mm
geometry:
  substrate [Arlon AD410 (tm)] = box(corner=(-subX/2+10mm, -subY/2, -subZ), size=(subX, subY, subZ))
  patch1 = rectangle(corner=(-patchW/2, 0mm, 0mm), x_size=patchW, y_size=patchL)
  patch2 = rectangle(corner=(-patchW/2, 1 * (patchL + arraySpaceL), 0mm), x_size=patchW, y_size=patchL)
  patch3 = rectangle(corner=(-patchW/2, 2*(patchL + arraySpaceL ), 0mm), x_size=patchW, y_size=patchL)
  patch4 = rectangle(corner=(-patchW/2, 3*(patchL + arraySpaceL), 0mm), x_size=patchW, y_size=patchL)
  QWTtrace = rectangle(corner=(-qwtWidth/2, -arraySpaceL, 0mm), x_size=qwtWidth, y_size=4*patchL + 4*arraySpaceL)
  50ohm = rectangle(corner=(-fiftyOhmW/2, -5mm - arraySpaceL, 0mm), x_size=fiftyOhmW, y_size=5mm)
  Rectangle1 = rectangle(corner=(-fiftyOhmW/2, -(arraySpaceL + 5mm), -subZ), z_size=subZ, x_size=fiftyOhmW)
  RadiatingSurface [vacuum] = region(absolute_offset=3.5714286mm on all sides)
  inlet1_1 = rectangle(corner=(-qwtWidth, 0mm, 0mm), x_size=qwtWidth*2, y_size=qwtWidth*2)
  inlet1_2 = rectangle(corner=(-qwtWidth, patchL-(qwtWidth*2), 0mm), x_size=qwtWidth*2, y_size=qwtWidth*2)
  inlet2_1 = rectangle(corner=(-qwtWidth, 1 * (patchL + arraySpaceL), 0mm), x_size=qwtWidth*2, y_size=qwtWidth*2)
  inlet2_2 = rectangle(corner=(-qwtWidth, 1*(patchL + arraySpaceL)+(patchL-(qwtWidth*2)), 0mm), x_size=qwtWidth*2, y_size=qwtWidth*2)
  inlet3_1 = rectangle(corner=(-qwtWidth, 2 * (patchL + arraySpaceL), 0mm), x_size=qwtWidth*2, y_size=qwtWidth*2)
  inlet3_2 = rectangle(corner=(-qwtWidth, 2*(patchL + arraySpaceL)+(patchL-(qwtWidth*2)), 0mm), x_size=qwtWidth*2, y_size=qwtWidth*2)
  inlet4_1 = rectangle(corner=(-qwtWidth, 3 * (patchL + arraySpaceL), 0mm), x_size=qwtWidth*2, y_size=qwtWidth*2)
  inlet4_2 = rectangle(corner=(-qwtWidth, 3*(patchL + arraySpaceL)+(patchL-(qwtWidth*2)), 0mm), x_size=qwtWidth*2, y_size=qwtWidth*2)
  inlet1_1.unite(inlet1_2)
  inlet2_1.unite(inlet2_2)
  inlet3_1.unite(inlet3_2)
  inlet4_1.unite(inlet4_2)
  patch1.subtract(inlet1_1)
  patch2.subtract(inlet2_1)
  patch3.subtract(inlet3_1)
  patch4.subtract(inlet4_1)
  50ohm.unite(patch1..patch4, QWTtrace)
  coordinate_system RelativeCS1 = origin=(0mm, 9.4mm, 0mm) x=(1mm, 0mm, 0mm) y=(0mm, 1mm, 0mm)
  Rectangle2 = rectangle(corner=(-fiftyOhmW/2 + 1*6.4mm, -(arraySpaceL + 5mm), -subZ), z_size=subZ, x_size=fiftyOhmW)
  Rectangle3 = rectangle(corner=(-fiftyOhmW/2 + 2*6.4mm, -(arraySpaceL + 5mm), -subZ), z_size=subZ, x_size=fiftyOhmW)
  Rectangle4 = rectangle(corner=(-fiftyOhmW/2 + 3*6.4mm, -(arraySpaceL + 5mm), -subZ), z_size=subZ, x_size=fiftyOhmW)
  coordinate_system RelativeCS2 = origin=(9.6mm, 0mm, 0mm) x=(1mm, 0mm, 0mm) y=(0mm, 1mm, 0mm) in RelativeCS1
  50ohm_1, 50ohm_2, 50ohm_3 = 50ohm.duplicate_along_line(step=(6.4mm, 0mm, 0mm), total=4)
boundaries and excitations:
  Open1: Radiation Objects=RadiatingSurface
  traceAu: Finite Conductivity Objects=[50ohm_3, 50ohm_2, 50ohm_1, 50ohm] Conductivity=41100000 Permeability=1 IsInternal
  ground: Perfect E Faces=substrate.face(-z)
  port1: Lumped Port Objects=Rectangle1 Modes{Mode1{IntLine{middle of Rectangle1.edge(z opposite corner) -> middle of Rectangle1.edge(z at corner)} CharImp=Zpi RenormImp=50ohm}} Impedance=50ohm
  port2: Lumped Port Objects=Rectangle2 Modes{Mode1{IntLine{middle of Rectangle2.edge(z opposite corner) -> middle of Rectangle2.edge(z at corner)} CharImp=Zpi RenormImp=50ohm}} Impedance=50ohm
  port3: Lumped Port Objects=Rectangle3 Modes{Mode1{IntLine{middle of Rectangle3.edge(z opposite corner) -> middle of Rectangle3.edge(z at corner)} CharImp=Zpi RenormImp=50ohm}} Impedance=50ohm
  port4: Lumped Port Objects=Rectangle4 Modes{Mode1{IntLine{Rectangle4.edge(z opposite corner) at 0.476 along -> Rectangle4.edge(z at corner) at 0.524 along} CharImp=Zpi RenormImp=50ohm}} Impedance=50ohm
setups:
  Setup1: HfssDriven Frequency=28GHz MaxDeltaS=0.02 MaximumPasses=6 MinimumPasses=1 MinimumConvergedPasses=1 PercentRefinement=30 BasisOrder=0 PortAccuracy=2
    sweep Sweep: 20GHz to 36GHz, 401 points; Type=Interpolating InterpTolerance=0.2 InterpMaxSolns=250 InterpUsePortImped=false PassivityErrorTolerance=0.0001
source amplitudes:
  port1:1: 1W 0deg
  port2:1, port3:1, port4:1: 0W 0deg
radiation setups:
  3D: Infinite Sphere Theta=0deg..180deg step 2deg Phi=-180deg..180deg step 2deg
  Elevation: Infinite Sphere Theta=-180deg..180deg step 1deg Phi=0deg..90deg step 90deg
  Azimuth: Infinite Sphere Theta=90deg..90deg step 0deg Phi=-180deg..180deg step 1deg
  ff_2d: Infinite Sphere Theta=-180deg..180deg step 2deg Phi=0deg..90deg step 90deg
  Infinite Sphere1: Infinite Sphere Theta=0deg..180deg step 2deg Phi=0deg..360deg step 2deg CoordSystem=RelativeCS2
  coord: Infinite Sphere Theta=0deg..180deg step 2deg Phi=0deg..360deg step 2deg CoordSystem=RelativeCS2
reports:
  Gain Plot 1: dB(GainTotal) vs Phi, Theta on Setup1 : LastAdaptive, 3D [Freq=28GHz]
  Gain Plot 1_1: dB(GainTotal) vs Phi, Theta on Setup1 : LastAdaptive, 3D [Freq=28GHz]
  Gain Plot 2: dB(GainTotal) vs Phi, Theta on Setup1 : LastAdaptive, coord [Freq=28GHz]
  Directivity Plot 1: dB(DirTotal) vs Theta on Setup1 : LastAdaptive, ff_2d [Phi=all Freq=28GHz]

design 1_1_singlepatch (HFSS, DrivenModal, model units mm)
variables:
  subX = 20mm
  subY = 30mm
  subZ = 0.3mm
  patchW = 3.25mm
  patchL = 2.85mm
  arraySpaceL = 2.65mm
  qwtWidth = 0.3mm
  fiftyOhmW = 0.85mm
geometry:
  substrate [Arlon AD410 (tm)] = box(corner=(-subX/2, -subY/2, -subZ), size=(subX, subY, subZ))
  patch1 = rectangle(corner=(-patchW/2, 0mm, 0mm), x_size=patchW, y_size=patchL)
  QWTtrace = rectangle(corner=(-qwtWidth/2, -arraySpaceL, 0mm), x_size=qwtWidth, y_size=1*patchL + 1*arraySpaceL)
  50ohm = rectangle(corner=(-fiftyOhmW/2, -5mm - arraySpaceL, 0mm), x_size=fiftyOhmW, y_size=5mm)
  Rectangle1 = rectangle(corner=(-fiftyOhmW/2, -(arraySpaceL + 5mm), -subZ), z_size=subZ, x_size=fiftyOhmW)
  RadiatingSurface [vacuum] = region(absolute_offset=3.5714286mm on all sides)
  coordinate_system RelativeCS1 = origin=(-0.15mm, 9.675mm, 0mm) x=(1mm, 0mm, 0mm) y=(0mm, 1mm, 0mm)
  50ohm.unite(patch1, QWTtrace)
boundaries and excitations:
  ground: Perfect E Faces=substrate.face(-z)
  Open1: Radiation Objects=RadiatingSurface
  port1: Lumped Port Objects=Rectangle1 Modes{Mode1{IntLine{middle of Rectangle1.edge(z opposite corner) -> middle of Rectangle1.edge(z at corner)} CharImp=Zpi RenormImp=50ohm}} Impedance=50ohm
setups:
  Setup1: HfssDriven Frequency=28GHz MaxDeltaS=0.02 MaximumPasses=6 MinimumPasses=1 MinimumConvergedPasses=1 PercentRefinement=30 BasisOrder=0 PortAccuracy=2
    sweep Sweep: 20GHz to 36GHz, 401 points; Type=Interpolating InterpTolerance=0.2 InterpMaxSolns=250 InterpUsePortImped=false PassivityErrorTolerance=0.0001
source amplitudes:
  port1:1: 1W 0deg
radiation setups:
  3D: Infinite Sphere Theta=0deg..180deg step 2deg Phi=-180deg..180deg step 2deg
  Elevation: Infinite Sphere Theta=-180deg..180deg step 1deg Phi=0deg..90deg step 90deg
  Azimuth: Infinite Sphere Theta=90deg..90deg step 0deg Phi=-180deg..180deg step 1deg
  ff_2d: Infinite Sphere Theta=-180deg..180deg step 2deg Phi=0deg..90deg step 90deg
  Infinite Sphere1: Infinite Sphere Theta=0deg..180deg step 2deg Phi=0deg..360deg step 2deg
  coord: Infinite Sphere Theta=0deg..180deg step 2deg Phi=0deg..360deg step 2deg CoordSystem=RelativeCS1
reports:
  Gain Plot 1: dB(GainTotal) vs Phi, Theta on Setup1 : LastAdaptive, 3D [Freq=28GHz]
  Gain Plot 2: dB(GainTotal) vs Phi, Theta on Setup1 : LastAdaptive, coord [Freq=28GHz]
  Gain Plot 3: dB(GainTotal) vs Theta on Setup1 : LastAdaptive, ff_2d [Phi=all Freq=28GHz]
  Directivity Plot 1: dB(DirTotal) vs Theta on Setup1 : LastAdaptive, ff_2d [Phi=all Freq=28GHz]; markers m1 at 0deg

design 0_0_patchExample (HFSS, DrivenModal, model units mm)
variables:
  subX = 15mm
  subY = 15mm
  subZ = 0.787mm
  patchW = 4.232mm
  patchL = 3.06mm
  arraySpaceL = 2.65mm
  qwtWidth = 0.3mm
  fiftyOhmW = 0.85mm
  feedLength = 1.4685mm
  feedWidth = 0.3mm
geometry:
  substrate [Rogers RT/duroid 5880 (tm)] = box(corner=(-subX/2, -subY/2, -subZ), size=(subX, subY, subZ))
  patch1 = rectangle(corner=(-patchW/2, 0mm, 0mm), x_size=patchW, y_size=patchL)
  QWTtrace = rectangle(corner=(-feedWidth/2, -feedLength, 0mm), x_size=feedWidth, y_size=feedLength)
  Rectangle1 = rectangle(corner=(-feedWidth/2, -feedLength, -subZ), z_size=subZ, x_size=feedWidth)
  RadiatingSurface [vacuum] = region(absolute_offset=3.5714286mm on all sides)
  coordinate_system RelativeCS1 = origin=(-0.15mm, 9.675mm, 0mm) x=(1mm, 0mm, 0mm) y=(0mm, 1mm, 0mm)
  patch1.unite(QWTtrace)
boundaries and excitations:
  Open1: Radiation Objects=RadiatingSurface
  copper: Finite Conductivity Objects=patch1 Conductivity=59600000 Permeability=1 IsInternal
  ground: Perfect E Faces=substrate.face(-z)
  port1: Lumped Port Objects=Rectangle1 Modes{Mode1{IntLine{middle of Rectangle1.edge(z opposite corner) -> middle of Rectangle1.edge(z at corner)} CharImp=Zpi RenormImp=50ohm}} Impedance=50ohm
setups:
  Setup1: HfssDriven Frequency=28GHz MaxDeltaS=0.02 MaximumPasses=6 MinimumPasses=1 MinimumConvergedPasses=1 PercentRefinement=30 BasisOrder=0 PortAccuracy=2
    sweep Sweep: 26GHz to 30GHz, 401 points; Type=Interpolating InterpTolerance=0.2 InterpMaxSolns=250 InterpUsePortImped=false PassivityErrorTolerance=0.0001
source amplitudes:
  port1:1: 1W 0deg
radiation setups:
  3D: Infinite Sphere Theta=0deg..180deg step 2deg Phi=-180deg..180deg step 2deg
  Elevation: Infinite Sphere Theta=-180deg..180deg step 1deg Phi=0deg..90deg step 90deg
  Azimuth: Infinite Sphere Theta=90deg..90deg step 0deg Phi=-180deg..180deg step 1deg
  ff_2d: Infinite Sphere Theta=-180deg..180deg step 2deg Phi=0deg..90deg step 90deg
  Infinite Sphere1: Infinite Sphere Theta=0deg..180deg step 2deg Phi=0deg..360deg step 2deg
  coord: Infinite Sphere Theta=0deg..180deg step 2deg Phi=0deg..360deg step 2deg CoordSystem=RelativeCS1
reports:
  Gain Plot 1: dB(GainTotal) vs Phi, Theta on Setup1 : LastAdaptive, 3D [Freq=28GHz]
  Gain Plot 2: dB(GainTotal) vs Phi, Theta on Setup1 : LastAdaptive, coord [Freq=28GHz]
  Gain Plot 3: dB(GainTotal) vs Theta on Setup1 : LastAdaptive, ff_2d [Phi=all Freq=28GHz]
  Directivity Plot 1: dB(DirTotal) vs Theta on Setup1 : LastAdaptive, ff_2d [Phi=all Freq=28GHz]; markers m1 at 0deg

design 0_1_patchArlonSingle (HFSS, DrivenModal, model units mm)
variables:
  subX = 15mm
  subY = 15mm
  subZ = 0.3mm
  patchW = 3.349mm
  patchL = 2.533mm
  arraySpaceL = 2.65mm
  qwtWidth = 0.3mm
  fiftyOhmW = 0.85mm
  feedLength = 1.4685mm
  feedWidth = 0.3mm
geometry:
  substrate [Arlon AD410 (tm)] = box(corner=(-subX/2, -subY/2, -subZ), size=(subX, subY, subZ))
  patch1 = rectangle(corner=(-patchW/2, 0mm, 0mm), x_size=patchW, y_size=patchL)
  QWTtrace = rectangle(corner=(-feedWidth/2, -feedLength, 0mm), x_size=feedWidth, y_size=feedLength)
  Rectangle1 = rectangle(corner=(-feedWidth/2, -feedLength, -subZ), z_size=subZ, x_size=feedWidth)
  RadiatingSurface [vacuum] = region(absolute_offset=3.5714286mm on all sides)
  coordinate_system RelativeCS1 = origin=(-0.15mm, 9.675mm, 0mm) x=(1mm, 0mm, 0mm) y=(0mm, 1mm, 0mm)
  patch1.unite(QWTtrace)
  coordinate_system RelativeCS2 = origin=(0.15mm, -8.5072756mm, 0mm) x=(1mm, 0mm, 0mm) y=(0mm, 1mm, 0mm) in RelativeCS1
boundaries and excitations:
  Open1: Radiation Objects=RadiatingSurface
  gold: Finite Conductivity Objects=patch1 Conductivity=41100000 Permeability=1 IsInternal
  ground: Perfect E Faces=substrate.face(-z)
  port1: Lumped Port Objects=Rectangle1 Modes{Mode1{IntLine{middle of Rectangle1.edge(z opposite corner) -> middle of Rectangle1.edge(z at corner)} CharImp=Zpi RenormImp=50ohm}} Impedance=50ohm
setups:
  Setup1: HfssDriven Frequency=28GHz MaxDeltaS=0.02 MaximumPasses=6 MinimumPasses=1 MinimumConvergedPasses=1 PercentRefinement=30 BasisOrder=0 PortAccuracy=2
    sweep Sweep: 26GHz to 30GHz, 401 points; Type=Interpolating InterpTolerance=0.2 InterpMaxSolns=250 InterpUsePortImped=false PassivityErrorTolerance=0.0001
source amplitudes:
  port1:1: 1W 0deg
radiation setups:
  3D: Infinite Sphere Theta=0deg..180deg step 2deg Phi=-180deg..180deg step 2deg
  Elevation: Infinite Sphere Theta=-180deg..180deg step 1deg Phi=0deg..90deg step 90deg
  Azimuth: Infinite Sphere Theta=90deg..90deg step 0deg Phi=-180deg..180deg step 1deg
  ff_2d: Infinite Sphere Theta=-180deg..180deg step 2deg Phi=0deg..90deg step 90deg CoordSystem=RelativeCS2
  Infinite Sphere1: Infinite Sphere Theta=0deg..180deg step 2deg Phi=0deg..360deg step 2deg CoordSystem=RelativeCS2
  coord: Infinite Sphere Theta=0deg..180deg step 2deg Phi=0deg..360deg step 2deg CoordSystem=RelativeCS1
reports:
  Gain Plot 1: dB(GainTotal) vs Phi, Theta on Setup1 : LastAdaptive, 3D [Freq=28GHz]
  Gain Plot 2: dB(GainTotal) vs Phi, Theta on Setup1 : LastAdaptive, coord [Freq=28GHz]
  Gain Plot 3: dB(GainTotal) vs Theta on Setup1 : LastAdaptive, ff_2d [Phi=all Freq=28GHz]; markers m1 at 0deg
  Directivity Plot 1: dB(DirTotal) vs Theta on Setup1 : LastAdaptive, ff_2d [Phi=all Freq=28GHz]; markers m1 at 0deg

design 0_2_patchArlonDouble (HFSS, DrivenModal, model units mm)
variables:
  subX = 15mm
  subY = 20mm
  subZ = 0.3mm
  patchW = 3.349mm
  patchL = 2.533mm
  arraySpaceL = 2.65mm
  qwtWidth = 0.3mm
  fiftyOhmW = 0.85mm
  feedLength = 2.8205mm
  feedWidth = 0.3mm
geometry:
  substrate [Arlon AD410 (tm)] = box(corner=(-subX/2, -subY/2+patchL, -subZ), size=(subX, subY, subZ))
  patch1 = rectangle(corner=(-patchW/2, 0mm, 0mm), x_size=patchW, y_size=patchL)
  QWTtrace1 = rectangle(corner=(-feedWidth/2, -feedLength, 0mm), x_size=feedWidth, y_size=feedLength)
  Rectangle1 = rectangle(corner=(-feedWidth/2, -feedLength, -subZ), z_size=subZ, x_size=feedWidth)
  RadiatingSurface [vacuum] = region(absolute_offset=3.5714286mm on all sides)
  coordinate_system RelativeCS1 = origin=(-0.15mm, 9.675mm, 0mm) x=(1mm, 0mm, 0mm) y=(0mm, 1mm, 0mm)
  coordinate_system RelativeCS2 = origin=(0.15mm, -8.5072756mm, 0mm) x=(1mm, 0mm, 0mm) y=(0mm, 1mm, 0mm) in RelativeCS1
  QWTtrace2 = rectangle(corner=(-feedWidth/2, -feedLength+1*(feedLength+patchL), 0mm), x_size=feedWidth, y_size=feedLength)
  patch2 = rectangle(corner=(-patchW/2, 1*(patchL+feedLength), 0mm), x_size=patchW, y_size=patchL)
  QWTtrace1.unite(patch1, QWTtrace2, patch2)
boundaries and excitations:
  Open1: Radiation Objects=RadiatingSurface
  gold: Finite Conductivity Objects=QWTtrace1 Conductivity=41100000 Permeability=1 IsInternal
  ground: Perfect E Faces=substrate.face(-z)
  port1: Lumped Port Objects=Rectangle1 Modes{Mode1{IntLine{middle of Rectangle1.edge(z opposite corner) -> middle of Rectangle1.edge(z at corner)} CharImp=Zpi RenormImp=50ohm}} Impedance=50ohm
setups:
  Setup1: HfssDriven Frequency=28GHz MaxDeltaS=0.02 MaximumPasses=6 MinimumPasses=1 MinimumConvergedPasses=1 PercentRefinement=30 BasisOrder=0 PortAccuracy=2
    sweep Sweep: 26GHz to 30GHz, 401 points; Type=Interpolating InterpTolerance=0.2 InterpMaxSolns=250 InterpUsePortImped=false PassivityErrorTolerance=0.0001
source amplitudes:
  port1:1: 1W 0deg
radiation setups:
  3D: Infinite Sphere Theta=0deg..180deg step 2deg Phi=-180deg..180deg step 2deg
  Elevation: Infinite Sphere Theta=-180deg..180deg step 1deg Phi=0deg..90deg step 90deg
  Azimuth: Infinite Sphere Theta=90deg..90deg step 0deg Phi=-180deg..180deg step 1deg
  ff_2d: Infinite Sphere Theta=-180deg..180deg step 2deg Phi=0deg..90deg step 90deg CoordSystem=RelativeCS2
  Infinite Sphere1: Infinite Sphere Theta=0deg..180deg step 2deg Phi=0deg..360deg step 2deg CoordSystem=RelativeCS2
  coord: Infinite Sphere Theta=0deg..180deg step 2deg Phi=0deg..360deg step 2deg CoordSystem=RelativeCS1
reports:
  Gain Plot 1: dB(GainTotal) vs Phi, Theta on Setup1 : LastAdaptive, 3D [Freq=28GHz]
  Gain Plot 2: dB(GainTotal) vs Phi, Theta on Setup1 : LastAdaptive, coord [Freq=28GHz]
  Gain Plot 3: dB(GainTotal) vs Theta on Setup1 : LastAdaptive, ff_2d [Phi=all Freq=28GHz]; markers m1 at 0deg
  Directivity Plot 1: dB(DirTotal) vs Theta on Setup1 : LastAdaptive, ff_2d [Phi=all Freq=28GHz]; markers m1 at 0deg

design 0_3_patchArlonTriple (HFSS, DrivenModal, model units mm)
variables:
  subX = 15mm
  subY = 25mm
  subZ = 0.3mm
  patchW = 3.349mm
  patchL = 2.533mm
  arraySpaceL = 2.65mm
  qwtWidth = 0.3mm
  fiftyOhmW = 0.85mm
  feedLength = 2.8205mm
  feedWidth = 0.3mm
geometry:
  substrate [Arlon AD410 (tm)] = box(corner=(-subX/2, -subY/2+2*patchL, -subZ), size=(subX, subY, subZ))
  patch1 = rectangle(corner=(-patchW/2, 0mm, 0mm), x_size=patchW, y_size=patchL)
  feedline1 = rectangle(corner=(-feedWidth/2, -feedLength, 0mm), x_size=feedWidth, y_size=feedLength)
  Rectangle1 = rectangle(corner=(-feedWidth/2, -feedLength, -subZ), z_size=subZ, x_size=feedWidth)
  RadiatingSurface [vacuum] = region(absolute_offset=3.5714286mm on all sides)
  coordinate_system RelativeCS1 = origin=(-0.15mm, 9.675mm, 0mm) x=(1mm, 0mm, 0mm) y=(0mm, 1mm, 0mm)
  coordinate_system RelativeCS2 = origin=(0.15mm, -8.5072756mm, 0mm) x=(1mm, 0mm, 0mm) y=(0mm, 1mm, 0mm) in RelativeCS1
  feedline2 = rectangle(corner=(-feedWidth/2, -feedLength+1*(feedLength+patchL), 0mm), x_size=feedWidth, y_size=feedLength)
  patch2 = rectangle(corner=(-patchW/2, 1*(patchL+feedLength), 0mm), x_size=patchW, y_size=patchL)
  feedline3 = rectangle(corner=(-feedWidth/2, -feedLength+2*(feedLength+patchL), 0mm), x_size=feedWidth, y_size=feedLength)
  patch3 = rectangle(corner=(-patchW/2, 2*(patchL+feedLength), 0mm), x_size=patchW, y_size=patchL)
  patch3.unite(feedline3, patch2, feedline2, patch1, feedline1)
boundaries and excitations:
  Open1: Radiation Objects=RadiatingSurface
  ground: Perfect E Faces=substrate.face(-z)
  godl: Finite Conductivity Objects=patch3 Conductivity=41100000 Permeability=1 IsInternal
  port1: Lumped Port Objects=Rectangle1 Modes{Mode1{IntLine{middle of Rectangle1.edge(z opposite corner) -> middle of Rectangle1.edge(z at corner)} CharImp=Zpi RenormImp=50ohm}} Impedance=50ohm
setups:
  Setup1: HfssDriven Frequency=28GHz MaxDeltaS=0.02 MaximumPasses=6 MinimumPasses=1 MinimumConvergedPasses=1 PercentRefinement=30 BasisOrder=0 PortAccuracy=2
    sweep Sweep: 26GHz to 30GHz, 401 points; Type=Interpolating InterpTolerance=0.2 InterpMaxSolns=250 InterpUsePortImped=false PassivityErrorTolerance=0.0001
source amplitudes:
  port1:1: 1W 0deg
radiation setups:
  3D: Infinite Sphere Theta=0deg..180deg step 2deg Phi=-180deg..180deg step 2deg
  Elevation: Infinite Sphere Theta=-180deg..180deg step 1deg Phi=0deg..90deg step 90deg
  Azimuth: Infinite Sphere Theta=90deg..90deg step 0deg Phi=-180deg..180deg step 1deg
  ff_2d: Infinite Sphere Theta=-180deg..180deg step 2deg Phi=0deg..90deg step 90deg CoordSystem=RelativeCS2
  Infinite Sphere1: Infinite Sphere Theta=0deg..180deg step 2deg Phi=0deg..360deg step 2deg CoordSystem=RelativeCS2
  coord: Infinite Sphere Theta=0deg..180deg step 2deg Phi=0deg..360deg step 2deg CoordSystem=RelativeCS1
reports:
  Gain Plot 1: dB(GainTotal) vs Phi, Theta on Setup1 : LastAdaptive, 3D [Freq=28GHz]
  Gain Plot 2: dB(GainTotal) vs Phi, Theta on Setup1 : LastAdaptive, coord [Freq=28GHz]
  Gain Plot 3: dB(GainTotal) vs Theta on Setup1 : LastAdaptive, ff_2d [Phi=all Freq=28GHz]; markers m1 at 0deg
  Directivity Plot 1: dB(DirTotal) vs Theta on Setup1 : LastAdaptive, ff_2d [Phi=all Freq=28GHz]; markers m1 at 0deg

design 0_4_patchArlonQuad (HFSS, DrivenModal, model units mm)
variables:
  subX = 15mm
  subY = 30mm
  subZ = 0.3mm
  patchW = 3.349mm
  patchL = 2.533mm
  arraySpaceL = 2.65mm
  qwtWidth = 0.3mm
  fiftyOhmW = 0.85mm
  feedLength = 2.8205mm
  feedWidth = 0.3mm
geometry:
  substrate [Arlon AD410 (tm)] = box(corner=(-subX/2, -subY/2+3*patchL, -subZ), size=(subX, subY, subZ))
  patch1 = rectangle(corner=(-patchW/2, 0mm, 0mm), x_size=patchW, y_size=patchL)
  feedline1 = rectangle(corner=(-feedWidth/2, -feedLength, 0mm), x_size=feedWidth, y_size=feedLength)
  Rectangle1 = rectangle(corner=(-feedWidth/2, -feedLength, -subZ), z_size=subZ, x_size=feedWidth)
  RadiatingSurface [vacuum] = region(absolute_offset=3.5714286mm on all sides)
  coordinate_system RelativeCS1 = origin=(-0.15mm, 9.675mm, 0mm) x=(1mm, 0mm, 0mm) y=(0mm, 1mm, 0mm)
  coordinate_system RelativeCS2 = origin=(0.15mm, -8.5072756mm, 0mm) x=(1mm, 0mm, 0mm) y=(0mm, 1mm, 0mm) in RelativeCS1
  feedline2 = rectangle(corner=(-feedWidth/2, -feedLength+1*(feedLength+patchL), 0mm), x_size=feedWidth, y_size=feedLength)
  patch2 = rectangle(corner=(-patchW/2, 1*(patchL+feedLength), 0mm), x_size=patchW, y_size=patchL)
  feedline3 = rectangle(corner=(-feedWidth/2, -feedLength+2*(feedLength+patchL), 0mm), x_size=feedWidth, y_size=feedLength)
  patch3 = rectangle(corner=(-patchW/2, 2*(patchL+feedLength), 0mm), x_size=patchW, y_size=patchL)
  feedline4 = rectangle(corner=(-feedWidth/2, -feedLength+3*(feedLength+patchL), 0mm), x_size=feedWidth, y_size=feedLength)
  patch4 = rectangle(corner=(-patchW/2, 3*(patchL+feedLength), 0mm), x_size=patchW, y_size=patchL)
  feedline1.unite(patch1, feedline2, patch2, feedline3, patch3, feedline4, patch4)
boundaries and excitations:
  Open1: Radiation Objects=RadiatingSurface
  gold: Finite Conductivity Objects=feedline1 Conductivity=41100000 Permeability=1 IsInternal
  ground: Perfect E Faces=substrate.face(-z)
  port1: Lumped Port Objects=Rectangle1 Modes{Mode1{IntLine{middle of Rectangle1.edge(z opposite corner) -> middle of Rectangle1.edge(z at corner)} CharImp=Zpi RenormImp=50ohm}} Impedance=50ohm
setups:
  Setup1: HfssDriven Frequency=28GHz MaxDeltaS=0.02 MaximumPasses=6 MinimumPasses=1 MinimumConvergedPasses=1 PercentRefinement=30 BasisOrder=0 PortAccuracy=2
    sweep Sweep: 26GHz to 30GHz, 401 points; Type=Interpolating InterpTolerance=0.2 InterpMaxSolns=250 InterpUsePortImped=false PassivityErrorTolerance=0.0001
source amplitudes:
  port1:1: 1W 0deg
radiation setups:
  3D: Infinite Sphere Theta=0deg..180deg step 2deg Phi=-180deg..180deg step 2deg
  Elevation: Infinite Sphere Theta=-180deg..180deg step 1deg Phi=0deg..90deg step 90deg
  Azimuth: Infinite Sphere Theta=90deg..90deg step 0deg Phi=-180deg..180deg step 1deg
  ff_2d: Infinite Sphere Theta=-180deg..180deg step 2deg Phi=0deg..90deg step 90deg CoordSystem=RelativeCS2
  Infinite Sphere1: Infinite Sphere Theta=0deg..180deg step 2deg Phi=0deg..360deg step 2deg CoordSystem=RelativeCS2
  coord: Infinite Sphere Theta=0deg..180deg step 2deg Phi=0deg..360deg step 2deg CoordSystem=RelativeCS1
reports:
  Gain Plot 1: dB(GainTotal) vs Phi, Theta on Setup1 : LastAdaptive, 3D [Freq=28GHz]
  Gain Plot 2: dB(GainTotal) vs Phi, Theta on Setup1 : LastAdaptive, coord [Freq=28GHz]
  Gain Plot 3: dB(GainTotal) vs Theta on Setup1 : LastAdaptive, ff_2d [Phi=all Freq=28GHz]; markers m1 at 0deg
  Directivity Plot 1: dB(DirTotal) vs Theta on Setup1 : LastAdaptive, ff_2d [Phi=all Freq=28GHz]; markers m1 at 0deg

design 0_5_patchArlonArray (HFSS, DrivenModal, model units mm)
variables:
  subX = (15*2.2) mm
  subY = 35mm
  subZ = 0.3mm
  patchW = 3.349mm
  patchL = 2.533mm
  arraySpaceL = 2.65mm
  qwtWidth = 0.3mm
  fiftyOhmW = 0.85mm
  feedLength = 2.8205mm
  feedWidth = 0.3mm
geometry:
  substrate [Arlon AD410 (tm)] = box(corner=(-subX/2+2.5*patchW, -subY/2+3*patchL, -subZ), size=(subX, subY, subZ))
  patch1 = rectangle(corner=(-patchW/2, 0mm, 0mm), x_size=patchW, y_size=patchL)
  feedline1 = rectangle(corner=(-feedWidth/2, -feedLength, 0mm), x_size=feedWidth, y_size=feedLength)
  Rectangle1 = rectangle(corner=(-feedWidth/2, -feedLength, -subZ), z_size=subZ, x_size=feedWidth)
  RadiatingSurface [vacuum] = region(absolute_offset=3.5714286mm on all sides)
  coordinate_system RelativeCS1 = origin=(-0.15mm, 9.675mm, 0mm) x=(1mm, 0mm, 0mm) y=(0mm, 1mm, 0mm)
  coordinate_system RelativeCS2 = origin=(0.15mm, -8.5072756mm, 0mm) x=(1mm, 0mm, 0mm) y=(0mm, 1mm, 0mm) in RelativeCS1
  feedline2 = rectangle(corner=(-feedWidth/2, -feedLength+1*(feedLength+patchL), 0mm), x_size=feedWidth, y_size=feedLength)
  patch2 = rectangle(corner=(-patchW/2, 1*(patchL+feedLength), 0mm), x_size=patchW, y_size=patchL)
  feedline3 = rectangle(corner=(-feedWidth/2, -feedLength+2*(feedLength+patchL), 0mm), x_size=feedWidth, y_size=feedLength)
  patch3 = rectangle(corner=(-patchW/2, 2*(patchL+feedLength), 0mm), x_size=patchW, y_size=patchL)
  feedline4 = rectangle(corner=(-feedWidth/2, -feedLength+3*(feedLength+patchL), 0mm), x_size=feedWidth, y_size=feedLength)
  patch4 = rectangle(corner=(-patchW/2, 3*(patchL+feedLength), 0mm), x_size=patchW, y_size=patchL)
  feedline1.unite(patch1, feedline2, patch2, feedline3, patch3, feedline4, patch4)
  feedline1_1, feedline1_2, feedline1_3 = feedline1.duplicate_along_line(step=(6.375mm, 0mm, 0mm), total=4) in RelativeCS2
  Rectangle1_1, Rectangle1_2, Rectangle1_3 = Rectangle1.duplicate_along_line(step=(6.375mm, 0mm, 0mm), total=4) in RelativeCS2
boundaries and excitations:
  Open1: Radiation Objects=RadiatingSurface
  gold: Finite Conductivity Objects=[feedline1_1, feedline1_2, feedline1_3, feedline1] Conductivity=41100000 Permeability=1 IsInternal
  ground: Perfect E Faces=substrate.face(-z)
  port1: Lumped Port Objects=Rectangle1 Modes{Mode1{IntLine{middle of Rectangle1.edge(z opposite corner) -> middle of Rectangle1.edge(z at corner)} CharImp=Zpi RenormImp=50ohm}} Impedance=50ohm
  p2: Lumped Port Objects=Rectangle1_1 Modes{Mode1{IntLine{middle of Rectangle1_1.edge(2 of 4) -> middle of Rectangle1_1.edge(4 of 4)} CharImp=Zpi RenormImp=50ohm}} Impedance=50ohm
  p3: Lumped Port Objects=Rectangle1_2 Modes{Mode1{IntLine{middle of Rectangle1_2.edge(2 of 4) -> middle of Rectangle1_2.edge(4 of 4)} CharImp=Zpi RenormImp=50ohm}} Impedance=50ohm
  p4: Lumped Port Objects=Rectangle1_3 Modes{Mode1{IntLine{middle of Rectangle1_3.edge(2 of 4) -> middle of Rectangle1_3.edge(4 of 4)} CharImp=Zpi RenormImp=50ohm}} Impedance=50ohm
setups:
  Setup1: HfssDriven Frequency=28GHz MaxDeltaS=0.02 MaximumPasses=6 MinimumPasses=1 MinimumConvergedPasses=1 PercentRefinement=30 BasisOrder=0 PortAccuracy=2
    sweep Sweep: 26GHz to 30GHz, 401 points; Type=Interpolating InterpTolerance=0.2 InterpMaxSolns=250 InterpUsePortImped=false PassivityErrorTolerance=0.0001
source amplitudes:
  port1:1, p2:1, p3:1, p4:1: 1W 0deg
radiation setups:
  3D: Infinite Sphere Theta=0deg..180deg step 2deg Phi=-180deg..180deg step 2deg
  Elevation: Infinite Sphere Theta=-180deg..180deg step 1deg Phi=0deg..90deg step 90deg
  Azimuth: Infinite Sphere Theta=90deg..90deg step 0deg Phi=-180deg..180deg step 1deg
  ff_2d: Infinite Sphere Theta=-180deg..180deg step 2deg Phi=0deg..90deg step 90deg CoordSystem=RelativeCS2
  Infinite Sphere1: Infinite Sphere Theta=0deg..180deg step 2deg Phi=0deg..360deg step 2deg CoordSystem=RelativeCS2
  coord: Infinite Sphere Theta=0deg..180deg step 2deg Phi=0deg..360deg step 2deg CoordSystem=RelativeCS1
reports:
  Gain Plot 1: dB(GainTotal) vs Phi, Theta on Setup1 : LastAdaptive, 3D [Freq=28GHz]
  Gain Plot 2: dB(GainTotal) vs Phi, Theta on Setup1 : LastAdaptive, coord [Freq=28GHz]
  Gain Plot 3: dB(GainTotal) vs Theta on Setup1 : LastAdaptive, ff_2d [Phi=all Freq=28GHz]; markers m1 at 0deg
  Directivity Plot 1: dB(DirTotal) vs Theta on Setup1 : LastAdaptive, ff_2d [Phi=all Freq=28GHz]; markers m1 at 0deg
